ADE simulation setup
Run mode: Single Run, Sweeps and Corners
Tests:
  oxymeter_idan_oximeter_design_1: oxymeter_idan/oximeter_design/schematic, simulator spectre
    Variables: alpha = 0.5; finger = 1; temperature = 25
    Outputs: /I21/bcasn; /I21/bcasp
Global variables:
  alpha = 0.5
