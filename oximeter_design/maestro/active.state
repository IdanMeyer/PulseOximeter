ADE simulation setup
Test oxymeter_idan_oximeter_design_1: oxymeter_idan/oximeter_design/schematic, simulator spectre
  Models: /data/tsmc/65LP/pdk/models/spectre/toplevel.scs[tt_lib]
  Variables: finger = 1; alpha = 0.5
  Temperature: 27.0
  Analysis dc: (saves the operating point)
  Signals: /I0/biasp (terminal), /I0/bcasp (terminal), /I0/bcasn (terminal), /I0/biasn (terminal), /I15/bcasn (terminal), /I15/bcasp (terminal), /I15/biasn (terminal), /I15/biasp (terminal), /I1/bcasn (terminal), /I1/bcasp (terminal), /I1/biasn (terminal), /I1/biasp (terminal), /I12/bcasn (terminal), /I12/biasn (terminal), /I12/biasp (terminal), /I19/bcasn (terminal), /I19/bcasp (terminal), /I19/biasn (terminal), /I19/biasp (terminal), /I18/bcasn (terminal), /I18/bcasp (terminal), /I18/biasn (terminal), /I18/biasp (terminal), /I17/bcasn (terminal), /I17/bcasp (terminal), /I17/biasn (terminal), /I17/biasp (terminal), /I21/biasn (terminal), /I21/biasp (terminal), /I21/bcasp (terminal), /I21/bcasn (terminal)
Run mode: Single Run, Sweeps and Corners
Global variables:
  alpha = 0.5
Setup values for test oxymeter_idan_oximeter_design_1: temperature = 25
